ADE simulation setup
Run mode: Single Run, Sweeps and Corners
Tests:
  fanout-tests_fanout-question-4_1: fanout-tests/fanout-question-4/schematic, simulator spectre
