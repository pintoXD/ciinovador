ADE simulation setup
Test fanout-tests_fanout-question-4_1: fanout-tests/fanout-question-4/schematic, simulator spectre
  Models: /home/tools/cadence/gpdk/gpdk045_v_6_0/gpdk045/../models/spectre/gpdk045.scs[mc]
  Temperature: 27
  Stimulus vdd!: voltage dc dc=1 srcType=dc
  Analysis dc: sweep /v0.dc start=0 stop=1 step=0.001
  Output deriv(VS("/out"))
  Signals: /out, /dut_in
Run mode: Single Run, Sweeps and Corners
