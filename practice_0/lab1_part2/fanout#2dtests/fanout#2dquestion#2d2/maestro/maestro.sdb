ADE simulation setup
Run mode: Single Run, Sweeps and Corners
Tests:
  fanout-tests_fanout-question-2_1: fanout-tests/fanout-question-2/schematic, simulator spectre
    Outputs: /in; /dut_out; /out; tpd
