ADE simulation setup
Test fanout-tests_inverter_1: fanout-tests/inverter/schematic, simulator spectre
  Models: /home/tools/cadence/gpdk/gpdk045_v_6_0/gpdk045/../models/spectre/gpdk045.scs[mc]
  Temperature: 27
  Stimulus vdd!: voltage dc dc=1 srcType=dc
  Stimulus in: voltage pulse val0=0 val1=1 period=2n width=1n srcType=pulse
  Analysis tran: stop=4n
  Signals: /in, /dut_out, /dut_in, /out
Run mode: Single Run, Sweeps and Corners
