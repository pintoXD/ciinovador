ADE simulation setup
Run mode: Single Run, Sweeps and Corners
Tests:
  fanout-tests_inverter_1: fanout-tests/inverter/schematic, simulator spectre
    Outputs: /in; /dut_in; /dut_out; /out; tpd
