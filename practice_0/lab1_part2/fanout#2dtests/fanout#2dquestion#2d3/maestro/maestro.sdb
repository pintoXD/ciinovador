ADE simulation setup
Run mode: Single Run, Sweeps and Corners
Tests:
  fanout-tests_fanout-question-3_1: fanout-tests/fanout-question-3/schematic, simulator spectre
    Outputs: /in; "/dut_in"; /dut_in; /dut_out; "/out"; /out; tpd
