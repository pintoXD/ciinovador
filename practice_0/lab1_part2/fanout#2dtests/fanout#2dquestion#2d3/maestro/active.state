ADE simulation setup
Test fanout-tests_fanout-question-3_1: fanout-tests/fanout-question-3/schematic, simulator spectre
  Models: /home/tools/cadence/gpdk/gpdk045_v_6_0/gpdk045/../models/spectre/gpdk045.scs[mc]
  Temperature: 27
  Stimulus in: voltage pulse val0=0 val1=1 period=2n width=1n srcType=pulse
  Stimulus vdd!: voltage dc dc=1 srcType=dc
  Analysis tran: stop=4n
  Output tpdr = delay(?wf1 VT("/dut_in") ?value1 0.5 ?edge1 "rising" ?nth1 1 ?td1 0.0 ?tol1 nil ?wf2 VT("/dut_out") ?value2 0.5 ?edge2 "falling" ?nth2 1 ?tol2 nil ?td2 nil ?stop nil ?multiple nil)
  Output tpdf = delay(?wf1 VT("/dut_in") ?value1 0.5 ?edge1 "falling" ?nth1 1 ?td1 0.0 ?tol1 nil ?wf2 VT("/dut_out") ?value2 0.5 ?edge2 "rising" ?nth2 1 ?tol2 nil ?td2 nil ?stop nil ?multiple nil)
  Output tpd = ((tpdr + tpdf) / 2)
  Signals: /in, /dut_in, /dut_out, /out
Run mode: Single Run, Sweeps and Corners
