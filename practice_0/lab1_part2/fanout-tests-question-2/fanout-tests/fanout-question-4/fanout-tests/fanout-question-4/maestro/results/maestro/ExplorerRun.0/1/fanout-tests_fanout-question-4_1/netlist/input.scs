// Design: fanout-tests/fanout-question-4
simulator lang=spectre
global 0 vdd!
parameters temperature=27
include "/home/tools/cadence/gpdk/gpdk045_v_6_0/gpdk045/../models/spectre/gpdk045.scs" section=mc

// fanout-tests/fanout-question-4/schematic
NM0 (out dut_in 0 0) g45n1svt w=(120n) l=45n nf=1 m=(1)
PM0 (out dut_in vdd! vdd!) g45p1svt w=(360n) l=45n nf=1 m=(1)
v0 (dut_in 0) vsource dc=1 type=dc
include "./_graphical_stimuli.scs"
simulatorOptions options temp=27
dc dc dev=v0 param=dc start=0 stop=1 step=0.001
save out
