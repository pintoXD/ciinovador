// Design: fanout-tests/fanout-question-2
simulator lang=spectre
global 0 vdd!
parameters temperature=27
include "/home/tools/cadence/gpdk/gpdk045_v_6_0/gpdk045/../models/spectre/gpdk045.scs" section=mc

// fanout-tests/fanout-question-2/schematic
NM11 (out net26 0 0) g45n1svt w=(3u) l=45n nf=1 m=(25)
NM8 (net26 dut_out 0 0) g45n1svt w=(600n) l=45n nf=1 m=(25)
NM6 (dut_out in 0 0) g45n1svt w=(120n) l=45n nf=1 m=(25)
PM9 (out net26 vdd! vdd!) g45p1svt w=(6u) l=45n nf=1 m=(25)
PM6 (net26 dut_out vdd! vdd!) g45p1svt w=(1.2u) l=45n nf=1 m=(25)
PM4 (dut_out in vdd! vdd!) g45p1svt w=(240n) l=45n nf=1 m=(25)
include "./_graphical_stimuli.scs"
simulatorOptions options temp=27
tran tran stop=4n
save in dut_out out
