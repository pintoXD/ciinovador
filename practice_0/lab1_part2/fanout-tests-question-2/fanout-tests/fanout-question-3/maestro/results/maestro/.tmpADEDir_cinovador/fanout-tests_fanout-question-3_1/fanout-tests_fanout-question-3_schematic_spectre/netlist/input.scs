// Design: fanout-tests/fanout-question-3
simulator lang=spectre
global 0 vdd!
parameters temperature=27
include "/home/tools/cadence/gpdk/gpdk045_v_6_0/gpdk045/../models/spectre/gpdk045.scs" section=mc

// fanout-tests/fanout-question-3/schematic
NM8 (out dut_out 0 0) g45n1svt w=(600n) l=45n nf=1 m=(25)
NM6 (dut_out dut_in 0 0) g45n1svt w=(120n) l=45n nf=1 m=(25)
NM4 (dut_in net1 0 0) g45n1svt w=(120n) l=45n nf=1 m=(5)
NM0 (net1 in 0 0) g45n1svt w=(120n) l=45n nf=1 m=(1)
PM6 (out dut_out vdd! vdd!) g45p1svt w=(1.2u) l=45n nf=1 m=(25)
PM4 (dut_out dut_in vdd! vdd!) g45p1svt w=(240n) l=45n nf=1 m=(25)
PM2 (dut_in net1 vdd! vdd!) g45p1svt w=(240n) l=45n nf=1 m=(5)
PM0 (net1 in vdd! vdd!) g45p1svt w=(240n) l=45n nf=1 m=(1)
include "./_graphical_stimuli.scs"
simulatorOptions options temp=27
tran tran stop=4n
save in dut_in dut_out out
