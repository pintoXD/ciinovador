// Design: fanout-tests/inverter
simulator lang=spectre
global 0 vdd!
parameters temperature=27
include "/home/tools/cadence/gpdk/gpdk045_v_6_0/gpdk045/../models/spectre/gpdk045.scs" section=mc

// fanout-tests/inverter/schematic
NM11 (out net26 0 0) g45n1svt w=(3u) l=45n nf=1 m=(25)
NM8 (net26 dut_out 0 0) g45n1svt w=(600n) l=45n nf=1 m=(25)
NM6 (dut_out dut_in 0 0) g45n1svt w=(120n) l=45n nf=1 m=(25)
NM4 (dut_in net1 0 0) g45n1svt w=(120n) l=45n nf=1 m=(5)
NM0 (net1 in 0 0) g45n1svt w=(120n) l=45n nf=1 m=(1)
PM9 (out net26 vdd! vdd!) g45p1svt w=(3u) l=45n nf=1 m=(50)
PM6 (net26 dut_out vdd! vdd!) g45p1svt w=(600n) l=45n nf=1 m=(50)
PM4 (dut_out dut_in vdd! vdd!) g45p1svt w=(120n) l=45n nf=1 m=(50)
PM2 (dut_in net1 vdd! vdd!) g45p1svt w=(120n) l=45n nf=1 m=(10)
PM0 (net1 in vdd! vdd!) g45p1svt w=(120n) l=45n nf=1 m=(2)
include "./_graphical_stimuli.scs"
simulatorOptions options temp=27
tran tran stop=4n
save in dut_out dut_in out
