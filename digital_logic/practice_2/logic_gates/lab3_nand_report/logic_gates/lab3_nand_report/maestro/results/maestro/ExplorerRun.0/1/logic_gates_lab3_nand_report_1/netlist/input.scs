// Design: logic_gates/lab3_nand_report
simulator lang=spectre
global 0 vdd!
parameters temperature=27
include "/home/tools/cadence/gpdk/gpdk045_v_6_0/gpdk045/../models/spectre/gpdk045.scs" section=mc

// logic_gates/lab3_nand_report/schematic
NM3 (net1 in_b 0 0) g45n1svt w=(120n) l=45n nf=1 m=(1)
NM0 (out in_a net1 0) g45n1svt w=(120n) l=45n nf=1 m=(1)
PM1 (out in_a vdd! vdd!) g45p1svt w=(120n) l=45n nf=1 m=(1)
PM0 (out in_b vdd! vdd!) g45p1svt w=(120n) l=45n nf=1 m=(1)
C0 (out 0) capacitor c=10f
V0 (in_a 0) vsource type=pulse val0=0 val1=1 period=1u delay=1p rise=100.0p fall=100.0p width=500.0n
V2 (in_b 0) vsource dc=1 type=dc
include "./_graphical_stimuli.scs"
simulatorOptions options temp=27
tran tran stop=100u
save in_a in_b out
