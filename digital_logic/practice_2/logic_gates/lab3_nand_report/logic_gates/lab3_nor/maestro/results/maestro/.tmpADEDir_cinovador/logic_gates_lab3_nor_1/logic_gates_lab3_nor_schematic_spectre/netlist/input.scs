// Design: logic_gates/lab3_nor
simulator lang=spectre
global 0 vdd!
parameters temperature=50
include "/home/tools/cadence/gpdk/gpdk045_v_6_0/gpdk045/../models/spectre/gpdk045.scs" section=mc

// logic_gates/lab3_nor/schematic
NM3 (out in_a 0 0) g45n1svt w=(120n) l=45n nf=1 m=(1)
NM0 (out in_b 0 0) g45n1svt w=(120n) l=45n nf=1 m=(1)
PM1 (out in_b net1 vdd!) g45p1svt w=(120n) l=45n nf=1 m=(1)
PM0 (net1 in_a vdd! vdd!) g45p1svt w=(120n) l=45n nf=1 m=(1)
C0 (out 0) capacitor c=10f
V3 (in_b 0) vsource type=pulse val0=0 val1=1.2 period=900.0n delay=1p rise=100.0p fall=100.0p width=450.0n
V0 (in_a 0) vsource type=pulse val0=0 val1=1.2 period=1u delay=1p rise=100.0p fall=100.0p width=500.0n
V2 (net3 0) vsource dc=0 type=dc
V1 (net2 0) vsource dc=0 type=dc
include "./_graphical_stimuli.scs"
simulatorOptions options temp=50
tran tran stop=100u
save in_a in_b out PM0:d C0:1 C0:1 V1:p V1:p PM0:s vdd!
