ADE simulation setup
Run mode: Single Run, Sweeps and Corners
Tests:
  logic_gates_lab3_nand_report_1: logic_gates/lab3_nand_report/schematic, simulator spectre
