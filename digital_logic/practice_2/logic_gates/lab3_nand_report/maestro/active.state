ADE simulation setup
Test logic_gates_lab3_nand_report_1: logic_gates/lab3_nand_report/schematic, simulator spectre
  Models: /home/tools/cadence/gpdk/gpdk045_v_6_0/gpdk045/../models/spectre/gpdk045.scs[mc]
  Temperature: 27
  Stimulus vdd!: voltage dc dc=1 srcType=dc
  Analysis tran: stop=100u
  Signals: /in_a, /in_b, /out
Run mode: Single Run, Sweeps and Corners
