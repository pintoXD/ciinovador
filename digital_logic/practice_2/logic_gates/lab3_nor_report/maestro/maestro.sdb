ADE simulation setup
Run mode: Single Run, Sweeps and Corners
Tests:
  logic_gates_lab3_nor_report_1: logic_gates/lab3_nor_report/schematic, simulator spectre
