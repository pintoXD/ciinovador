// Design: logic_gates/q3_expr
simulator lang=spectre
global 0 vdd!
parameters temperature=27
include "/home/tools/cadence/gpdk/gpdk045_v_6_0/gpdk045/../models/spectre/gpdk045.scs" section=mc

// logic_gates/q3_expr/schematic
NM15 (net9 in_c 0 0) g45n1svt w=(120n) l=45n nf=1 m=(1)
NM14 (out net2 0 0) g45n1svt w=(120n) l=45n nf=1 m=(1)
NM12 (net11 in_b net9 0) g45n1svt w=(120n) l=45n nf=1 m=(1)
NM11 (net2 in_a net11 0) g45n1svt w=(120n) l=45n nf=1 m=(1)
PM13 (vdd! net2 out vdd!) g45p1svt w=(120n) l=45n nf=1 m=(1)
PM12 (vdd! in_c net2 vdd!) g45p1svt w=(120n) l=45n nf=1 m=(1)
PM11 (vdd! in_b net2 vdd!) g45p1svt w=(120n) l=45n nf=1 m=(1)
PM9 (vdd! in_a net2 vdd!) g45p1svt w=(120n) l=45n nf=1 m=(1)
IN_C (in_c 0) vsource type=pulse val0=1 val1=0 period=3n delay=1p rise=1p fall=1p width=1.5n
IN_B (in_b 0) vsource type=pulse val0=0 val1=1 period=2n delay=1p rise=1p fall=1p width=1n
IN_A (in_a 0) vsource type=pulse val0=0 val1=1 period=1n delay=1p rise=1p fall=1p width=500.0p
include "./_graphical_stimuli.scs"
simulatorOptions options temp=27
tran tran stop=100n
