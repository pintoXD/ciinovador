ADE simulation setup
Run mode: Single Run, Sweeps and Corners
Tests:
  logic_gates_q3_expr_1: logic_gates/q3_expr/schematic, simulator spectre
