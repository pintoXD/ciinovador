ADE simulation setup
Test logic_gates_q3_expr_1: logic_gates/q3_expr/schematic, simulator spectre
  Models: /home/tools/cadence/gpdk/gpdk045_v_6_0/gpdk045/../models/spectre/gpdk045.scs[mc]
  Temperature: 27
  Stimulus vdd!: voltage dc dc=1 srcType=dc
  Analysis tran: stop=100n
  Signals: /in_a, /in_b, /in_c, /out
Run mode: Single Run, Sweeps and Corners
