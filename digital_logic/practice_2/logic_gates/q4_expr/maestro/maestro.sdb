ADE simulation setup
Run mode: Single Run, Sweeps and Corners
Tests:
  logic_gates_q4_expr_1: logic_gates/q4_expr/schematic, simulator spectre
