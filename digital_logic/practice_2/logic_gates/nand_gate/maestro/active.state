ADE simulation setup
Test logic_gates_nand_gate_1: logic_gates/nand_gate/schematic, simulator spectre
  Models: /home/tools/cadence/gpdk/gpdk045_v_6_0/gpdk045/../models/spectre/gpdk045.scs[mc]
  Temperature: 27
  Stimulus vdd!: voltage dc dc=1 srcType=dc
  Analysis tran: stop=100n
  Signals: /in_a, /in_b, /out, /I0/vdd! (terminal)
Run mode: Single Run, Sweeps and Corners
