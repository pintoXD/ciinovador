ADE simulation setup
Run mode: Single Run, Sweeps and Corners
Tests:
  logic_gates_nand_gate_1: logic_gates/nand_gate/schematic, simulator spectre
    Outputs: /in_a; /I0/vdd!
