// Design: logic_gates/nor_gate
simulator lang=spectre
global 0 vdd!
parameters temperature=27
include "/home/tools/cadence/gpdk/gpdk045_v_6_0/gpdk045/../models/spectre/gpdk045.scs" section=mc

// logic_gates/nor_gate/schematic
NM3 (out in_a 0 0) g45n1svt w=(120n) l=45n nf=1 m=(1)
NM0 (out in_b 0 0) g45n1svt w=(120n) l=45n nf=1 m=(1)
PM1 (net7 in_b out out) g45p1svt w=(120n) l=45n nf=1 m=(1)
PM0 (vdd! in_a net7 net7) g45p1svt w=(120n) l=45n nf=1 m=(1)
C0 (out 0) capacitor c=10f
V1 (in_b 0) vsource type=pulse val0=0 val1=1 period=4n delay=1p rise=1p fall=1p width=2n
V0 (in_a 0) vsource type=pulse val0=0 val1=1 period=2n delay=1p rise=1p fall=1p width=1n
include "./_graphical_stimuli.scs"
simulatorOptions options temp=27
tran tran stop=100n
save in_a in_b out
