ADE simulation setup
Run mode: Single Run, Sweeps and Corners
Tests:
  logic_gates_nor_gate_1: logic_gates/nor_gate/schematic, simulator spectre
