ADE simulation setup
Run mode: Single Run, Sweeps and Corners
Tests:
  logic_gates_q2_expr_1: logic_gates/q2_expr/schematic, simulator spectre
