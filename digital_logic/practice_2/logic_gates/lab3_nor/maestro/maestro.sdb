ADE simulation setup
Run mode: Single Run, Sweeps and Corners
Tests:
  logic_gates_lab3_nor_1: logic_gates/lab3_nor/schematic, simulator spectre
    Variables: temperature = 0:50:100
    Outputs: /PM0/D; nil; ((average(IT("/PM0/D") ?continuous nil) * 1.2) average(VT("/vdd!"))); ((average(IT("/PM0/D") ?continuous nil)) average(VT("/vdd!"))); (average(IT("/PM0/D")) * average(VT("/vdd!"))); power_consumed; current_consumed; ((average(IT("/PM0/S")) ?continuous nil) * average(VT("/vdd!")))
