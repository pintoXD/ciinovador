ADE simulation setup
Test logic_gates_lab3_nor_1: logic_gates/lab3_nor/schematic, simulator spectre
  Models: /home/tools/cadence/gpdk/gpdk045_v_6_0/gpdk045/../models/spectre/gpdk045.scs[mc]
  Temperature: 50
  Stimulus vdd!: voltage dc dc=1.2 srcType=dc
  Analysis tran: stop=100u
  Output average(IT("/PM0/S"))
  Output (average(IT("/PM0/S")) * average(VT("/vdd!")))
  Output average(IT("/PM0/S") ?continuous nil)
  Output (average(IT("/PM0/S") ?continuous nil) * average(VT("/vdd!")))
  Signals: /in_a, /in_b, /out, /PM0/D (terminal), /C0/PLUS (terminal), /C0/MINUS (terminal), /V1/MINUS (terminal), /V1/PLUS (terminal), /PM0/S (terminal), /vdd!
Run mode: Single Run, Sweeps and Corners
Setup values for test logic_gates_lab3_nor_1: temperature = 0:50:100
