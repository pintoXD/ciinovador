ADE simulation setup
Test logic_gates_lab3_nor_1: logic_gates/lab3_nor/schematic, simulator spectre
  Models: /home/tools/cadence/gpdk/gpdk045_v_6_0/gpdk045/../models/spectre/gpdk045.scs[mc]
  Variables: temperature = 0
  Temperature: 50
  Stimulus vdd!: voltage dc dc=1.2 srcType=dc
  Analysis tran: stop=100u
  Output current_consumed = average(IT("/PM0/S"))
  Output power_consumed = (average(IT("/PM0/S")) * average(VT("/vdd!")))
  Output tpdf = delay(?wf1 VT("/in_a") ?value1 0.6 ?edge1 "rising" ?nth1 1 ?td1 0.0 ?tol1 nil ?wf2 VT("/out") ?value2 0.6 ?edge2 "falling" ?nth2 1 ?tol2 nil ?td2 nil ?stop nil ?multiple nil)
  Output tpdr = delay(?wf1 VT("/in_a") ?value1 0.6 ?edge1 "falling" ?nth1 1 ?td1 0.0 ?tol1 nil ?wf2 VT("/out") ?value2 0.6 ?edge2 "rising" ?nth2 1 ?tol2 nil ?td2 nil ?stop nil ?multiple nil)
  Signals: /in_a, /in_b, /out, /PM0/D (terminal), /C0/PLUS (terminal), /C0/MINUS (terminal), /V1/MINUS (terminal), /V1/PLUS (terminal), /PM0/S (terminal)
Run mode: Single Run, Sweeps and Corners
Setup values for test logic_gates_lab3_nor_1: temperature = 0:50:100
