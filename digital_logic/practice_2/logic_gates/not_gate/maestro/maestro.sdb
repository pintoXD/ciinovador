ADE simulation setup
Run mode: Single Run, Sweeps and Corners
Tests:
  logic_gates_not_gate_1: logic_gates/not_gate/schematic, simulator spectre
    Outputs: /in; /out
