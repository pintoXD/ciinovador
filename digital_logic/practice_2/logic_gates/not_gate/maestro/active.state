ADE simulation setup
Test logic_gates_not_gate_1: logic_gates/not_gate/schematic, simulator spectre
  Models: /home/tools/cadence/gpdk/gpdk045_v_6_0/gpdk045/../models/spectre/gpdk045.scs[mc]
  Temperature: 27
  Stimulus in: voltage pulse val0=0 val1=1 period=2n width=1n srcType=pulse
  Stimulus vdd!: voltage dc dc=1 srcType=dc
  Analysis tran: stop=100n
  Signals: /in, /out
Run mode: Single Run, Sweeps and Corners
