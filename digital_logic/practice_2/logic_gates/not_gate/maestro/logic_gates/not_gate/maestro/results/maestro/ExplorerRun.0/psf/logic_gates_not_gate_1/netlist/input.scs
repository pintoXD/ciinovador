// Point Netlist Generated on: Oct 31 15:58:27 2024
// Generated for: spectre
// Design Netlist Generated on: Oct 31 15:57:22 2024
// Design library name: logic_gates
// Design cell name: not_gate
// Design view name: schematic
simulator lang=spectre
include "ade_e.scs"
global 0 vdd!
parameters temperature=27
include "/home/tools/cadence/gpdk/gpdk045_v_6_0/gpdk045/../models/spectre/gpdk045.scs" section=mc

// Library name: logic_gates
// Cell name: not_gate
// View name: schematic
NM0 (out in 0 0) g45n1svt w=(120n) l=45n nf=1 as=16.8f ad=16.8f ps=520n \
        pd=520n nrd=1.16667 nrs=1.16667 sa=140n sb=140n sd=160n \
        sca=226.00151 scb=0.11734 scc=0.02767 m=(1)
PM0 (vdd! in out out) g45p1svt w=(120n) l=45n nf=1 as=16.8f ad=16.8f \
        ps=520n pd=520n nrd=1.16667 nrs=1.16667 sa=140n sb=140n sd=160n \
        sca=226.00151 scb=0.11734 scc=0.02767 m=(1)
include "./_graphical_stimuli.scs"
simulatorOptions options psfversion="1.4.0" reltol=1e-3 vabstol=1e-6 \
    iabstol=1e-12 temp=27 tnom=27 scalem=1.0 scale=1.0 gmin=1e-12 rforce=1 \
    maxnotes=5 maxwarns=5 digits=5 cols=80 pivrel=1e-3 \
    sensfile="../psf/sens.output" checklimitdest=psf
tran tran stop=100n write="spectre.ic" writefinal="spectre.fc" \
    annotate=status maxiters=5
finalTimeOP info what=oppoint where=rawfile
modelParameter info what=models where=rawfile
element info what=inst where=rawfile
outputParameter info what=output where=rawfile
designParamVals info what=parameters where=rawfile
primitives info what=primitives where=rawfile
subckts info what=subckts where=rawfile
save in out
saveOptions options save=allpub
