ADE simulation setup
Run mode: Single Run, Sweeps and Corners
Tests:
  logic_gates_q1_expr_1: logic_gates/q1_expr/schematic, simulator spectre
