ADE simulation setup
Test logic_gates_q1_expr_1: logic_gates/q1_expr/schematic, simulator spectre
  Models: /home/tools/cadence/gpdk/gpdk045_v_6_0/gpdk045/../models/spectre/gpdk045.scs[mc]
  Temperature: 27
  Stimulus vdd!: voltage dc dc=1 srcType=dc
  Analysis tran: stop=100n
  Signals: /in_a, /in_c, /in_b, /in_d, /out
Run mode: Single Run, Sweeps and Corners
